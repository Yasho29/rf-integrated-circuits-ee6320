ADE simulation setup
Test ee6320_2026_VCO_Divider_1: ee6320_2026/VCO_Divider/schematic, simulator spectre
  Models: /home/ee23b114/cadence/EE6320_2026/modelsLibs/ibm013.scs
  Variables: W12 = 10u; W1 = 25u; VDC = 0.2; Res = 500; Wt = 5u; WINVn = 1u; WINVp = 3u; fo = 7G
  Temperature: 27
  Analysis tran: stop=25n errpreset=moderate
  Analysis pss: engine=Harmonic Balance fund=7G harms=5 p=/Pls n=/Pls2
  Output v /Vtestb; tran (V) = vtime('tran "/Vtestb") (unticked)
  Output v /D1; tran (V) = vtime('tran "/D1") (unticked)
  Output v /Pls; tran (V) = vtime('tran "/Pls") (unticked)
  Output v /net6; dc (V) = v("/net6" ?result "dc") (unticked)
  Output v /net7; dc (V) = v("/net7" ?result "dc") (unticked)
Run mode: Single Run, Sweeps and Corners
