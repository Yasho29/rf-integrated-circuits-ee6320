ADE simulation setup
Run mode: Single Run, Sweeps and Corners
Tests:
  ee6320_2026_VCO_Divider_1: ee6320_2026/VCO_Divider/schematic, simulator spectre
    Variables: W12 = 10u; W1 = 25u; VDC = 0.2; Res = 500; Wt = 5u; WINVn = 1u; WINVp = 3u; fo = 7G
